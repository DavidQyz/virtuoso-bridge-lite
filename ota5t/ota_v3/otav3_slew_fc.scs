// FC baseline slew: buffer step
simulator lang=spectre
global 0
include "/mnt/hgfs/share_folder/tsmc18_HRI_1K_1.8V_5V_1.0fF_GA_GB_1P6M_4K_MIM_15K/models/spectre/c018bcd_gen2_v1d6_usage.scs" section=pre_simu
include "/mnt/hgfs/share_folder/tsmc18_HRI_1K_1.8V_5V_1.0fF_GA_GB_1P6M_4K_MIM_15K/models/spectre/c018bcd_gen2_v1d6_usage.scs" section=tt_lib

Vdd   (vdd   0)     vsource dc=1.8
Vstep (vinp  0)     vsource type=pulse val0=0.35 val1=0.95 delay=2e-08 \
    rise=1n fall=1n width=4e-07
Rfb   (out  vinn)   resistor r=1m

Vbt   (vbtail 0)    vsource dc=1.30
Vbn   (vbn   0)     vsource dc=0.52
Vbnc  (vbnc  0)     vsource dc=0.90
Vbpc  (vbpc  0)     vsource dc=0.95
nodeset out=0.65 vinn=0.65 ntail=1.6 nA2=1.5 nB2=1.5
M0  (ntail vbtail vdd  vdd)  pch_mac w=4u l=1u
M1  (nA    vinp  ntail vdd)  pch_mac w=3u l=1u
M2  (nB    vinn  ntail vdd)  pch_mac w=3u l=1u
M3  (nA    vbn   0     0)    nch_mac w=1u l=1u
M4  (nB    vbn   0     0)    nch_mac w=1u l=1u
M5  (nA2   vbnc  nA    0)    nch_mac w=1u l=0.5u
M6  (out   vbnc  nB    0)    nch_mac w=1u l=0.5u
M7  (nA2   vbpc  nA3   vdd)  pch_mac w=2u l=0.5u
M8  (out   vbpc  nB3   vdd)  pch_mac w=2u l=0.5u
M9  (nA3   nA2   vdd   vdd)  pch_mac w=2u l=0.5u
M10 (nB3   nA2   vdd   vdd)  pch_mac w=2u l=0.5u
CL  (out 0) capacitor c=50f
save out vinp
tr tran stop=8.2e-07 errpreset=conservative maxstep=200p

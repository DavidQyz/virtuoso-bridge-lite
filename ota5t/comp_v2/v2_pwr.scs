// COMP_V2 tprop testbench - low-swing 2V decision path
simulator lang=spectre
global 0
include "/mnt/hgfs/share_folder/tsmc18_HRI_1K_1.8V_5V_1.0fF_GA_GB_1P6M_4K_MIM_15K/models/spectre/c018bcd_gen2_v1d6_usage.scs" section=pre_simu
include "/mnt/hgfs/share_folder/tsmc18_HRI_1K_1.8V_5V_1.0fF_GA_GB_1P6M_4K_MIM_15K/models/spectre/c018bcd_gen2_v1d6_usage.scs" section=tt_lib

parameters vref=1.0 vcm=1.0 wcl=0.22u w5n=0.22u w5a=0.22u nf0=4 l6p=0.72u w21=0.88u wpc=0.22u lpc=2.4u wfb=0.22u lfb=1u

Vdd  (vdd 0)      vsource dc=1.8
Ven  (en 0)       vsource dc=1.8
Vnen (n_en 0)     vsource dc=0
Vvcm (comp_vcm 0) vsource dc=vcm
Vinn (inn 0)      vsource dc=vref
Vinp (inp 0)      vsource type=pwl wave=[ \
    0.000000e+00 0.000000  1.000000e-08 0.000000  1.024582e-08 0.104712  1.049164e-08 0.209378  1.073746e-08 0.313953  1.098328e-08 0.418389 \
    1.122911e-08 0.522642  1.147493e-08 0.626666  1.172075e-08 0.730415  1.196657e-08 0.833844  1.221239e-08 0.936907  1.245821e-08 1.039558 \
    1.270403e-08 1.141754  1.294985e-08 1.243449  1.319567e-08 1.344599  1.344149e-08 1.445159  1.368732e-08 1.545085  1.393314e-08 1.644333 \
    1.417896e-08 1.742860  1.442478e-08 1.840623  1.467060e-08 1.937578  1.491642e-08 2.033683  1.516224e-08 2.128896  1.540806e-08 2.223176 \
    1.565388e-08 2.316480  1.589971e-08 2.408768  1.614553e-08 2.500000  1.639135e-08 2.590135  1.663717e-08 2.679134  1.688299e-08 2.766958 \
    1.712881e-08 2.853568  1.737463e-08 2.938926  1.762045e-08 3.022996  1.786627e-08 3.105739  1.811209e-08 3.187120  1.835792e-08 3.267103 \
    1.860374e-08 3.345653  1.884956e-08 3.422736  1.909538e-08 3.498317  1.934120e-08 3.572363  1.958702e-08 3.644843  1.983284e-08 3.715724 \
    2.007866e-08 3.784975  2.032448e-08 3.852566  2.057030e-08 3.918467  2.081613e-08 3.982650  2.106195e-08 4.045085  2.130777e-08 4.105746 \
    2.155359e-08 4.164606  2.179941e-08 4.221640  2.204523e-08 4.276821  2.229105e-08 4.330127  2.253687e-08 4.381533  2.278269e-08 4.431018 \
    2.302852e-08 4.478559  2.327434e-08 4.524135  2.352016e-08 4.567727  2.376598e-08 4.609316  2.401180e-08 4.648882  2.425762e-08 4.686410 \
    2.450344e-08 4.721882  2.474926e-08 4.755283  2.499508e-08 4.786597  2.524090e-08 4.815813  2.548673e-08 4.842916  2.573255e-08 4.867895 \
    2.597837e-08 4.890738  2.622419e-08 4.911436  2.647001e-08 4.929980  2.671583e-08 4.946362  2.696165e-08 4.960574  2.720747e-08 4.972609 \
    2.745329e-08 4.982464  2.769912e-08 4.990134  2.794494e-08 4.995614  2.819076e-08 4.998903  2.843658e-08 5.000000  2.868240e-08 4.998903 \
    2.892822e-08 4.995614  2.917404e-08 4.990134  2.941986e-08 4.982464  2.966568e-08 4.972609  2.991150e-08 4.960574  3.015733e-08 4.946362 \
    3.040315e-08 4.929980  3.064897e-08 4.911436  3.089479e-08 4.890738  3.114061e-08 4.867895  3.138643e-08 4.842916  3.163225e-08 4.815813 \
    3.187807e-08 4.786597  3.212389e-08 4.755283  3.236971e-08 4.721882  3.261554e-08 4.686410  3.286136e-08 4.648882  3.310718e-08 4.609316 \
    3.335300e-08 4.567727  3.359882e-08 4.524135  3.384464e-08 4.478559  3.409046e-08 4.431018  3.433628e-08 4.381533  3.458210e-08 4.330127 \
    3.482793e-08 4.276821  3.507375e-08 4.221640  3.531957e-08 4.164606  3.556539e-08 4.105746  3.581121e-08 4.045085  3.605703e-08 3.982650 \
    3.630285e-08 3.918467  3.654867e-08 3.852566  3.679449e-08 3.784975  3.704031e-08 3.715724  3.728614e-08 3.644843  3.753196e-08 3.572363 \
    3.777778e-08 3.498317  3.802360e-08 3.422736  3.826942e-08 3.345653  3.851524e-08 3.267103  3.876106e-08 3.187120  3.900688e-08 3.105739 \
    3.925270e-08 3.022996  3.949853e-08 2.938926  3.974435e-08 2.853568  3.999017e-08 2.766958  4.023599e-08 2.679134  4.048181e-08 2.590135 \
    4.072763e-08 2.500000  4.097345e-08 2.408768  4.121927e-08 2.316480  4.146509e-08 2.223176  4.171091e-08 2.128896  4.195674e-08 2.033683 \
    4.220256e-08 1.937578  4.244838e-08 1.840623  4.269420e-08 1.742860  4.294002e-08 1.644333  4.318584e-08 1.545085  4.343166e-08 1.445159 \
    4.367748e-08 1.344599  4.392330e-08 1.243449  4.416912e-08 1.141754  4.441495e-08 1.039558  4.466077e-08 0.936907  4.490659e-08 0.833844 \
    4.515241e-08 0.730415  4.539823e-08 0.626666  4.564405e-08 0.522642  4.588987e-08 0.418389  4.613569e-08 0.313953  4.638151e-08 0.209378 \
    4.662734e-08 0.104712  4.687316e-08 0.000000  8.374631e-08 0.000000  8.399213e-08 0.104712  8.423795e-08 0.209378  8.448378e-08 0.313953 \
    8.472960e-08 0.418389  8.497542e-08 0.522642  8.522124e-08 0.626666  8.546706e-08 0.730415  8.571288e-08 0.833844  8.595870e-08 0.936907 \
    8.620452e-08 1.039558  8.645034e-08 1.141754  8.669617e-08 1.243449  8.694199e-08 1.344599  8.718781e-08 1.445159  8.743363e-08 1.545085 \
    8.767945e-08 1.644333  8.792527e-08 1.742860  8.817109e-08 1.840623  8.841691e-08 1.937578  8.866273e-08 2.033683  8.890855e-08 2.128896 \
    8.915438e-08 2.223176  8.940020e-08 2.316480  8.964602e-08 2.408768  8.989184e-08 2.500000  9.013766e-08 2.590135  9.038348e-08 2.679134 \
    9.062930e-08 2.766958  9.087512e-08 2.853568  9.112094e-08 2.938926  9.136676e-08 3.022996  9.161259e-08 3.105739  9.185841e-08 3.187120 \
    9.210423e-08 3.267103  9.235005e-08 3.345653  9.259587e-08 3.422736  9.284169e-08 3.498317  9.308751e-08 3.572363  9.333333e-08 3.644843 \
    9.357915e-08 3.715724  9.382498e-08 3.784975  9.407080e-08 3.852566  9.431662e-08 3.918467  9.456244e-08 3.982650  9.480826e-08 4.045085 \
    9.505408e-08 4.105746  9.529990e-08 4.164606  9.554572e-08 4.221640  9.579154e-08 4.276821  9.603736e-08 4.330127  9.628319e-08 4.381533 \
    9.652901e-08 4.431018  9.677483e-08 4.478559  9.702065e-08 4.524135  9.726647e-08 4.567727  9.751229e-08 4.609316  9.775811e-08 4.648882 \
    9.800393e-08 4.686410  9.824975e-08 4.721882  9.849558e-08 4.755283  9.874140e-08 4.786597  9.898722e-08 4.815813  9.923304e-08 4.842916 \
    9.947886e-08 4.867895  9.972468e-08 4.890738  9.997050e-08 4.911436  1.002163e-07 4.929980  1.004621e-07 4.946362  1.007080e-07 4.960574 \
    1.009538e-07 4.972609  1.011996e-07 4.982464  1.014454e-07 4.990134  1.016912e-07 4.995614  1.019371e-07 4.998903  1.021829e-07 5.000000 \
    1.024287e-07 4.998903  1.026745e-07 4.995614  1.029204e-07 4.990134  1.031662e-07 4.982464  1.034120e-07 4.972609  1.036578e-07 4.960574 \
    1.039036e-07 4.946362  1.041495e-07 4.929980  1.043953e-07 4.911436  1.046411e-07 4.890738  1.048869e-07 4.867895  1.051327e-07 4.842916 \
    1.053786e-07 4.815813  1.056244e-07 4.786597  1.058702e-07 4.755283  1.061160e-07 4.721882  1.063618e-07 4.686410  1.066077e-07 4.648882 \
    1.068535e-07 4.609316  1.070993e-07 4.567727  1.073451e-07 4.524135  1.075910e-07 4.478559  1.078368e-07 4.431018  1.080826e-07 4.381533 \
    1.083284e-07 4.330127  1.085742e-07 4.276821  1.088201e-07 4.221640  1.090659e-07 4.164606  1.093117e-07 4.105746  1.095575e-07 4.045085 \
    1.098033e-07 3.982650  1.100492e-07 3.918467  1.102950e-07 3.852566  1.105408e-07 3.784975  1.107866e-07 3.715724  1.110324e-07 3.644843 \
    1.112783e-07 3.572363  1.115241e-07 3.498317  1.117699e-07 3.422736  1.120157e-07 3.345653  1.122616e-07 3.267103  1.125074e-07 3.187120 \
    1.127532e-07 3.105739  1.129990e-07 3.022996  1.132448e-07 2.938926  1.134907e-07 2.853568  1.137365e-07 2.766958  1.139823e-07 2.679134 \
    1.142281e-07 2.590135  1.144739e-07 2.500000  1.147198e-07 2.408768  1.149656e-07 2.316480  1.152114e-07 2.223176  1.154572e-07 2.128896 \
    1.157030e-07 2.033683  1.159489e-07 1.937578  1.161947e-07 1.840623  1.164405e-07 1.742860  1.166863e-07 1.644333  1.169322e-07 1.545085 \
    1.171780e-07 1.445159  1.174238e-07 1.344599  1.176696e-07 1.243449  1.179154e-07 1.141754  1.181613e-07 1.039558  1.184071e-07 0.936907 \
    1.186529e-07 0.833844  1.188987e-07 0.730415  1.191445e-07 0.626666  1.193904e-07 0.522642  1.196362e-07 0.418389  1.198820e-07 0.313953 \
    1.201278e-07 0.209378  1.203736e-07 0.104712  1.206195e-07 0.000000  1.634926e-07 0.000000 ]

// --- front end: identical to COMP_CG/V4 (d g s b) ---
M0  (comp_out net78 inp  v_bb) pch_5_mac w=2u    l=0.5u  nf=nf0
M1  (net78   net78  inn  v_bb) pch_5_mac w=2u    l=0.5u  nf=4
M10 (v_bb    v_bb   inn  v_bb) pch_5_mac w=0.5u  l=0.5u  nf=1 multi=2
M11 (v_bb    v_bb   inp  v_bb) pch_5_mac w=0.5u  l=0.5u  nf=1 multi=2
M2  (comp_out v_bn  0    0)    nch_5_mac w=0.22u l=0.6u  nf=1
M3  (net78   v_bn   0    0)    nch_5_mac w=0.22u l=0.6u  nf=1
M22 (comp_vcm en    v_bn 0)    nch_mac   w=0.22u l=0.18u nf=1
M9  (v_bn    n_en   0    0)    nch_mac   w=0.22u l=0.18u nf=1
MD0 (v_bb    inn    inp  v_bb) pch_5_mac w=0.22u l=0.5u  nf=1
MD1 (inn     inp    v_bb v_bb) pch_5_mac w=0.22u l=0.5u  nf=1

// --- V2 decision path: dual-threshold parallel sense on `mid` ---
//  path A (= V4): M5 nmos5v G=comp_out -- 0.75V threshold, but gate OD keeps
//                 growing as comp_out -> INP (fast completion at high INN)
//  path B (new):  MCL clamp + M5B nmos2v G=yc -- 0.45V threshold, L=0.18u
//                 (fires early; rescues the low-INN region where comp_out
//                  plateaus near INP and never reaches path A's threshold)
MCL (comp_out vdd   yc   0)    nch_5_mac w=wcl   l=0.6u  nf=1
M5  (mid     comp_out 0  0)    nch_5_mac w=w5a   l=0.6u  nf=1
M5B (mid     yc     0    0)    nch_mac   w=w5n   l=0.18u nf=1
M6  (mid     comp_out vdd vdd) pch_5_mac w=0.22u l=0.5u  nf=1
M20 (out     mid    0    0)    nch_mac   w=0.22u l=0.18u nf=1
M21 (out     mid    vdd  vdd)  pch_mac   w=w21   l=0.18u nf=1

save inp out comp_out yc mid v_bn v_bb Vdd:p Vinp:p Vinn:p Vvcm:p
sw1 sweep param=vref values=[0.1 0.2 0.3 0.4 0.5 0.6 0.7 0.8 0.9 1 1.1 1.2 1.3 1.4 1.5 1.6 1.7 1.8 1.9 2 2.1 2.2 2.3 2.4 2.5 2.6 2.7 2.8 2.9 3 3.1 3.2 3.3 3.4 3.5 3.6 3.7 3.8 3.9 4 4.1 4.2 4.3 4.4 4.5 4.6 4.7 4.8 4.9] {
  tr tran stop=1.62493e-07 errpreset=conservative maxstep=50p
}

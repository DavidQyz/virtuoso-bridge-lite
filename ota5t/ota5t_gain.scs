// 5T OTA gain/psrr testbench (gain) - tsmc18 BCD gen2, ideal bias
simulator lang=spectre
global 0
include "/mnt/hgfs/share_folder/tsmc18_HRI_1K_1.8V_5V_1.0fF_GA_GB_1P6M_4K_MIM_15K/models/spectre/c018bcd_gen2_v1d6_usage.scs" section=pre_simu
include "/mnt/hgfs/share_folder/tsmc18_HRI_1K_1.8V_5V_1.0fF_GA_GB_1P6M_4K_MIM_15K/models/spectre/c018bcd_gen2_v1d6_usage.scs" section=tt_lib

// --- ideal supplies / bias ---
Vdd   (vdd   0)     vsource dc=1.8 mag=0
Vcm   (vincm 0)     vsource dc=0.9
Vbias (vbias 0)     vsource dc=0.63
Vinp  (vinp  vincm) vsource dc=0 mag=1

// --- open-loop AC bias network: DC short (L) sets vout=vcm, AC open ---
Lfb (vout vinn)  inductor l=1T
Cac (vinn vincm) capacitor c=1T

// --- 5T OTA core (d g s b) ---
M1 (vx    vinp vtail 0)   nch_mac w=3.0u l=1.0u nf=1
M2 (vout  vinn vtail 0)   nch_mac w=3.0u l=1.0u nf=1
M3 (vx    vx   vdd   vdd) pch_mac w=6.0u l=1.0u nf=1
M4 (vout  vx   vdd   vdd) pch_mac w=6.0u l=1.0u nf=1
M5 (vtail vbias 0    0)   nch_mac w=5.0u l=1.0u nf=1
CL (vout 0) capacitor c=1.0p

save vout vx vtail vinp vinn
opInfo info what=oppoint where=rawfile
ac ac start=1 stop=10G dec=20

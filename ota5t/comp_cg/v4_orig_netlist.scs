// test_rect/DBB1/schematic
subckt DBB1 IN1 IN2 OUT
    M1 (IN2 IN1 OUT OUT) pch_5_mac l=500n w=220.0n multi=1 nf=1 sigma=1 mismatchflag=1
    M0 (OUT IN2 IN1 OUT) pch_5_mac l=500n w=220.0n multi=1 nf=1 sigma=1 mismatchflag=1
ends DBB1

// test_rect/comparator_newV4_for_use_nb/schematic
M21 (OUT MID_INV VDD VDD) pch_mac l=180.0n w=880.0n multi=1 nf=1 sigma=1 mismatchflag=1
M6 (MID_INV COMP_OUT VDD VDD) pch_5_mac l=500n w=220.0n multi=1 nf=1 sigma=1 mismatchflag=1
M1 (net78 net78 INN V_BB) pch_5_mac l=500n w=2u multi=1 nf=4 sigma=1 mismatchflag=1
M0 (COMP_OUT net78 INP V_BB) pch_5_mac l=500n w=2u multi=1 nf=4 sigma=1 mismatchflag=1
M11 (V_BB V_BB INP V_BB) pch_5_mac l=500n w=500n multi=2 nf=1 sigma=1 mismatchflag=1
M10 (V_BB V_BB INN V_BB) pch_5_mac l=500n w=500n multi=2 nf=1 sigma=1 mismatchflag=1
M22 (COMP_VCM EN V_BN VSS) nch_mac l=180.0n w=220.0n multi=1 nf=1 sigma=1 mismatchflag=1
M9 (V_BN N_EN VSS VSS) nch_mac l=180.0n w=220.0n multi=1 nf=1 sigma=1 mismatchflag=1
M20 (OUT MID_INV VSS VSS) nch_mac l=180.0n w=220.0n multi=1 nf=1 sigma=1 mismatchflag=1
M5 (MID_INV COMP_OUT VSS VSS) nch_5_mac l=600n w=440.0n multi=2 nf=2 sigma=1 mismatchflag=1
M2 (COMP_OUT V_BN VSS VSS) nch_5_mac l=600n w=220.0n multi=1 nf=1 sigma=1 mismatchflag=1
M3 (net78 V_BN VSS VSS) nch_5_mac l=600n w=220.0n multi=1 nf=1 sigma=1 mismatchflag=1
I3 (INP INN V_BB) DBB1
